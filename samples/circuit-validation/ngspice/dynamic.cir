RF Link intrinsic Ebers-Moll RC reference
.temp 26.85
.model NPN1 NPN (IS=1e-15 BF=100 BR=1 TNOM=26.85)
V1 vcc 0 5
V2 in 0 DC 0.72 AC 1 SIN(0.72 0.01 1000000 0 0 90)
R3 in b 1000
R4 vcc c 1000
R5 c 0 10000
Q6 c b 0 NPN1
C6be b 0 2e-11
C6bc b c 2e-12
.options gmin=1e-18 reltol=1e-9 abstol=1e-15 vntol=1e-12
.control
set numdgt=15
set wr_singlescale
set wr_vecnames
noise v(c) V2 lin 9 10000 4010000
setplot noise1
wrdata noise.tsv onoise_spectrum
tran 0.25n 20u 19u 0.25n
linearize v(c)
wrdata transient.tsv v(c)
quit
.endc
.end
